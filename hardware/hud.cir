* HUD de procurado: os oito LEDs acesos ao mesmo tempo
*
* ngspice -b hardware/hud.cir
*
* O Mega 2560 não é simulado: cada pino em nível alto vira uma fonte de 5 V.
* O programa nunca acende os oito juntos (o giroflex alterna vermelho e azul),
* então a corrente total daqui é um teto.

.include leds.lib
.param vpino=5

* seis estrelas (pinos da barra dupla): pino -> 220 ohms -> LED amarelo -> GND
V52 g52 0 {vpino}
R52 g52 a52 220
D52 a52 0 LED_AMARELO
V53 g53 0 {vpino}
R53 g53 a53 220
D53 a53 0 LED_AMARELO
V50 g50 0 {vpino}
R50 g50 a50 220
D50 a50 0 LED_AMARELO
V51 g51 0 {vpino}
R51 g51 a51 220
D51 a51 0 LED_AMARELO
V49 g49 0 {vpino}
R49 g49 a49 220
D49 a49 0 LED_AMARELO
V48 g48 0 {vpino}
R48 g48 a48 220
D48 a48 0 LED_AMARELO

* giroflex: nos 5 V do Mega os dois levam 220 ohms (no ESP32 o azul levava 100)
V33 g33 0 {vpino}
R33 g33 a33 220
D33 a33 0 LED_VERMELHO
V32 g32 0 {vpino}
R32 g32 a32 220
D32 a32 0 LED_AZUL

.control
op
echo "corrente em cada LED (mA) e tensão sobre ele (V)"
print -i(V52)*1000 v(a52)
print -i(V33)*1000 v(a33)
print -i(V32)*1000 v(a32)
let total = -(i(V52)+i(V53)+i(V50)+i(V51)+i(V49)+i(V48)+i(V33)+i(V32))*1000
print total
.endc

.end
